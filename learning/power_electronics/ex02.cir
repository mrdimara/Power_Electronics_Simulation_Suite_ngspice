* Title : Half Wave Rectifier
* Analysis : Transient Analysis
.tran 1us 40ms uic
.include ex02.net
* Control Command
.control
set color0 white , set background as white
set color1 black ; set foreground as black
run
plot all
plot v(a) v(b)
.endc
