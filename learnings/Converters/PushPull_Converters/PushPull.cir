* ============================================
* Push-Pull Converter Simulation
* ============================================
.option reltol = 0.2 abstol = 0.2
.tran 0.1us 5ms uic
.include PushPull_Conv1.net
* ---------- CONTROL ----------
.control
run

set gnuplot_terminal qt
set color0 = white
set color1 = black
echo "OUTPUT VOLTAGE"
gnuplot plot1 v(/o)

echo "LOAD VOLTAGE"
gnuplot plot2 v(/o,/r1)

echo "DIODE CURRENTS"
gnuplot plot3 i(d1) i(d2)

echo "INDUCTOR CURRENT"
gnuplot plot4 i(l1)

echo "TRANSFORMER PRIMARY VOLTAGE"
gnuplot plot5 v(xfmpush1.n1, xfmpush1.n3)

echo "SWITCH CURRENTS"
gnuplot plot6 (viq1#branch) (viq2#branch)

echo "PWM SIGNALS"
gnuplot plot7 v(/g1) v(/g2) v(/g3) v(/g4)

.endc

.end
