*Feed Forward Control of Buck Converter
.option reltol=1e-6 abstol=1e-6 vntol=1e-6
.tran 1us 40ms uic
.include "buckclose2.net"
.control
run
listing
display
plot v(/C) v(/r)
plot all
.endc
