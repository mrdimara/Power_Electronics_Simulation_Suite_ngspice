*========================================================
* MPPT Simulation
*========================================================

.option reltol=1e-6 abstol=1e-9

.tran 1us 1000ms uic

.include mppt_net.net

.control

run

listing
display

set gnuplot_terminal=qt

*========================================================
* Initial Plots
*========================================================

* PV voltage
gnuplot pv_voltage v(/t)

* Output voltage
gnuplot output_voltage v(/o)

* Inductor node
gnuplot switch_node v(/p)

* PWM gate signal
gnuplot pwm_gate v(/g)

* MPPT power
gnuplot power v(/t)*(-i(Vipv1))

* Fast and slow filter comparison
gnuplot mppt_filters v(/pd) v(/pb)

* Duty control signal
gnuplot control_signal v(/d)

*========================================================
* Load Change Test
*========================================================

alter R1 70

echo "Load changed to 70 Ohms"

reset
run

*========================================================
* Plots After Load Change
*========================================================

gnuplot pv_voltage_after v(/t)

gnuplot output_voltage_after v(/o)

gnuplot power_after v(/t)*(-i(Vipv1))

gnuplot mppt_filters_after v(/pd) v(/pb)

gnuplot control_signal_after v(/d)

.endc
