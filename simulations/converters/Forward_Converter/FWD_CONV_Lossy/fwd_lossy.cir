*Forward Conv - Lossy Simulation
.option retol=0.01 abstol =0.01
.tran 0.1us 10ms uic
.include fwd_conv_lossy.net
*Control
.control
run
listing
display
set gnuplot_terminal = qt
gnuplot fwd_lossy i(L1) v(/o,/r) i(Vis1)
gnuplot fwd_lossy_current i(Vid1)
.endc
