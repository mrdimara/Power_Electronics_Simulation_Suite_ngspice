*========================================================
* RCC MPPT Simulation
*========================================================

.option reltol=1e-4
.option abstol=1e-6
.option method=gear
.option trtol=7

.tran 1us 100ms

.include edt01_mppt.sub
.include pv.sub
.include mppt_net.net

.save all

.control

run

set gnuplot_terminal=qt

*========================================================
* MAIN PLOTS
*========================================================

gnuplot pv_voltage v(/t)

gnuplot output_voltage v(/o)

gnuplot switch_node v(/p)

gnuplot pwm_signal v(/g)

gnuplot duty_control v(/d)

gnuplot mppt_filters v(/pd) v(/pb)

gnuplot power v(/t)*(i(Vipv1))

*========================================================
* LOAD STEP TEST
*========================================================

alter R1 70

echo "Load changed to 70 Ohms"

reset
run

gnuplot power_after v(/t)*(i(Vipv1))

gnuplot output_after v(/o)

.endc

.end
